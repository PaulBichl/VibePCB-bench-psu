* bench-psu: one output channel - control loop (crossover, phase margin) and 1 A <-> 3 A load steps
* run: ngspice -b boards/bench-psu/sim/buck_loop.cir      (a few seconds)
*
* covers: loop U11 U21
* range: cv_min_phase_margin_deg 45 - source=house:rules/sim-defaults.toml phase_margin_deg (1.6..16 V)
* range: cv_step_dev_mv 0 400 source=intent:assumptions "load transient" (2 A step / release, worst of 1.6..16 V)
*
* Why this deck exists: the LMR33630's compensation is internal and sized for a feedback gain of
* H = VREF/VOUT (TI keeps 4 x 22 uF from 3.3 V to 12 V at 400 kHz: crossover ~ H * K / (2 pi Cout)).
* The fail-safe FB network (Vout = 1.6 V + 120k * Isink) has H = 200k/(120k+200k) = 0.625 at EVERY output
* voltage, i.e. it loads the loop like a 1.6 V design even at 16 V, where the derated output capacitance is
* only ~18 uF. lag=1 adds Rs + Cs from FB to GND (R111/C113, R211/C213: 6.8k + 220 nF): H drops to 0.054 above ~100 Hz,
* DC regulation is unchanged.
*
* Averaged peak-current-mode model (Ridley):
*  - EA: transconductance into Rc + Cc; K = gm * Rc / Ri = 120 A/V, derived from the datasheet's CFF equation
*    (CFF = VOUT*COUT / (120 * RFBT * sqrt(VREF/VOUT)), which places the CFF zero at the crossover of a design with
*    fc = K * H / (2 pi COUT)). Assumed split: gm 1 mS, Rc 12 k, Ri 0.1 V/A, Cc 4.7 nF (zero 2.8 kHz),
*    EA high-frequency pole ~250 kHz. These internal values are NOT published: the absolute numbers are indicative,
*    the ratio between lag=0 and lag=1 is the point.
*  - Current loop: sampling double pole at fsw/2 with Q = 2/pi (adaptive slope compensation assumed).
*  - Peak current limit 4.5 A (ISC typ). Output caps at DC bias as in buck_loadpoints.cir, 20 mOhm shunt,
*    regulation point after the shunt, FB pin + NPN collector capacitance 5 pF.
*  - Load: Vout / 1 A resistor + 2 A current step (2 us edges) at 0.2 ms, released at 0.6 ms.

.param vout=5 lag=1
.param cout={vout < 2 ? 70u : vout < 4 ? 56u : vout < 6 ? 45u : vout < 13 ? 24u : 18u}
.param rs={lag > 0.5 ? 6.8k : 1e12} cs=220n
.param isink={(vout - 1.6) / 120k}
.param gm=1m rc=12k cc=4.7n ri=0.1
* sampling double pole as an RLC low-pass: wn = pi * fsw, Q = 2/pi, C = 1 nF
.param wn={3.14159 * 400k} qs={2 / 3.14159} chn=1n lhn={1 / (wn * wn * chn)} rhn={sqrt(lhn / chn) / qs}

* --- error amplifier + compensation ---
Bea 0 comp i = gm * (1.0 - v(fb))
Roea comp 0 10meg
Rc comp cz {rc}
Cc cz 0 {cc}
Chf comp 0 50p

* --- current loop: command -> sampling double pole -> inductor current ---
Bcmd icmd 0 v = min(4.5, max(-1, v(comp) / ri))
Rhn icmd hn1 {rhn}
Lhn hn1 ilv {lhn}
Chn ilv 0 {chn}
Bil 0 outb i = v(ilv)

* --- output: caps, shunt, load ---
Cout outb co_e {cout}
Rcout co_e 0 0.75m
Rsh outb out 20m
* output bulk at the terminal: C25 (OUT1; C26 on OUT2) 100 uF electrolytic, no DC-bias derating; ESR 0.3 Ohm assumed
* (6.3 x 7.7 mm general-purpose SMD electrolytic, not in the datasheet: ESR-zero ~5 kHz). Checked at 0.05 and 1 Ohm:
* CV phase margin >= 63 deg, CC >= 86 deg, 2 A step <= 323 mV - the result does not hinge on the ESR value.
C25 out cb_e 100u
Resr25 cb_e 0 0.3
Rload out 0 {vout / 1}
Istep out 0 pwl(0 0 0.2m 0 0.202m 2 0.6m 2 0.602m 0)

* --- feedback at the terminal: injection source for the loop gain, divider, current sink, lag network ---
Vinj fbtop out dc 0 ac 1
Rt fbtop fb 120k
Rb fb 0 200k
Isink fb 0 {isink}
Rs fb xs {rs}
Cs xs 0 {cs}
Cfb fb 0 5p

.control
  set noaskquit
  * the board's configuration (lag network fitted); `alterparam lag = 0` reproduces the rev A problem
  let pm_min = 999
  let dev_max = 0
  echo "Vout |  fc_kHz  PM_deg |  undershoot_mV  overshoot_mV  (1 -> 3 A step, 3 -> 1 A release)"
  foreach vo 1.6 3.3 5 12 16
    alterparam vout = $vo
    alterparam lag = 1
    reset
    ac dec 200 100 2meg
    let t = -v(out) / v(fbtop)
    let tmag = db(t)
    let tph = 180 / 3.14159 * cph(t)
    meas ac fc when tmag=0 fall=last
    meas ac phc find tph at=fc
    let pm = 180 + phc
    let fck = fc / 1000
    set fcv = "$&fck"
    set pmv = "$&pm"
    if pm < pm_min
      let pm_min = pm
    end
    tran 0.2u 1m
    meas tran v0 find v(out) at=0.199m
    meas tran vmin min v(out) from=0.2m to=0.6m
    meas tran vmax max v(out) from=0.6m to=1m
    let us = 1000 * (v0 - vmin)
    let os = 1000 * (vmax - v0)
    echo "$vo | $fcv $pmv | $&us $&os"
    if us > dev_max
      let dev_max = us
    end
    if os > dev_max
      let dev_max = os
    end
    destroy all
  end
  echo "cv_min_phase_margin_deg = $&pm_min"
  echo "cv_step_dev_mv = $&dev_max"
.endc
.end
